* ===========================================================
* Equivalent circuit: INDUCTOR LQW18AN10NJ00_10nH
* (DCR + L) series, with Cp and core-loss Rp in parallel across ports
* L   = 1.000000e-08 H
* DCR = 1.800000e-01 Ohm
* Cp  = 1.954498e-13 F
* Rp  = 1.193805e+03 Ohm  (core loss)
* SRF = 3600.000 MHz
* NOTE: behavioral / estimated model — not measured.
* ===========================================================
.subckt LQW18AN10NJ00_10nH 1 2
Rdcr 1 n1 1.800000e-01
Lind n1 2 1.000000e-08
Cpar 1 2 1.954498e-13
Rpar 1 2 1.193805e+03
.ends LQW18AN10NJ00_10nH
