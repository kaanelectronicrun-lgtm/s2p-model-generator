* ===========================================================
* Equivalent circuit: CAPACITOR Murata_GRM188R71C104KA01_100nF_16V_X7R_0603
* Series RLC model:  port1 -- ESL -- ESR -- C -- port2
* C   = 1.000000e-07 F
* ESR = 1.500000e-02 Ohm
* ESL = 9.894647e-10 H
* SRF = 16.000 MHz
* NOTE: behavioral / estimated model — not measured.
* ===========================================================
.subckt Murata_GRM188R71C104KA01_100nF_16V_X7R_0603 1 2
Lesl 1 n1 9.894647e-10
Resr n1 n2 1.500000e-02
Ccap n2 2 1.000000e-07
.ends Murata_GRM188R71C104KA01_100nF_16V_X7R_0603
