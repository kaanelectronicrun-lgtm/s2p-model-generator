* ===========================================================
* Equivalent circuit: CAPACITOR GJM1555C1H100_10pF_C0G
* Series RLC model:  port1 -- ESL -- ESR -- C -- port2
* C   = 1.000000e-11 F
* ESR = 7.000000e-02 Ohm
* ESL = 4.397621e-10 H
* SRF = 2400.000 MHz
* NOTE: behavioral / estimated model — not measured.
* ===========================================================
.subckt GJM1555C1H100_10pF_C0G 1 2
Lesl 1 n1 4.397621e-10
Resr n1 n2 7.000000e-02
Ccap n2 2 1.000000e-11
.ends GJM1555C1H100_10pF_C0G
