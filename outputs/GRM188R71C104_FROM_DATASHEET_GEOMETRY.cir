* ===========================================================
* Equivalent circuit: CAPACITOR GRM188R71C104_FROM_DATASHEET_GEOMETRY
* Series RLC model:  port1 -- ESL -- ESR -- C -- port2
* C   = 1.000000e-07 F
* ESR = 2.000000e-02 Ohm
* ESL = 7.000000e-10 H
* SRF = 19.023 MHz
* NOTE: behavioral / estimated model — not measured.
* ===========================================================
.subckt GRM188R71C104_FROM_DATASHEET_GEOMETRY 1 2
Lesl 1 n1 7.000000e-10
Resr n1 n2 2.000000e-02
Ccap n2 2 1.000000e-07
.ends GRM188R71C104_FROM_DATASHEET_GEOMETRY
